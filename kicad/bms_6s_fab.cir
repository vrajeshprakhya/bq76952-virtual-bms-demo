.title KiCad schematic
R13 +3V3 /SCL 4.7k
R14 +3V3 /+3V3_SWD 0
R12 +3V3 /SDA 4.7k
R15 /LED /LEDK 1k
C9 +3V3 GND 100n
C10 +3V3 GND 4.7u
C11 /VREFP GND 100n
R11 +3V3 /VREFP 0
C8 +3V3 GND 100n
R9 /CHG /CHG_G 100
R10 /CHG_G /PACK_M 10k
C12 /NRST GND 100n
U2 __U2
C3 /+3V3REG GND 1u
RF6 /VC7F /B5 100
RF5 /VC6F /B4 100
CF5 /VC7F /VC6F 1u
CF6 /VC8F /VC7F 1u
R1 /BATRC /B6 100
R2 /REGSRC /B6 100
C2 GND /REGSRC 1u
RF7 /VC8F /B6 100
CF4 /VC6F /VC5BF 1u
C1 GND /BATRC 1u
R3 /+3V3REG +3V3 0
U1 __U1
CF3 /VC3F /VC2F 1u
C4 /CAP1 GND 1u
RF1 /VC1F /B1 100
RF0 /VC0F GND 100
CF1 /VC1F /VC0F 1u
J1 __J1
CF2 /VC2F /VC1F 1u
RS1 __RS1
R5 /SRP_K /SRP 100
R6 /SRN_K /SRN 100
C7 /SRN /SRP 100n
J2 __J2
Q1 __Q1
R8 /DSG_G /SRB 10k
Q2 __Q2
R7 /DSG /DSG_G 100
J3 __J3
C5 /CAP2 GND 1u
D1 __D1
C6 /TS1 GND 100n
TH1 __TH1
RF3 /VC3F /B3 100
RF4 /VC5BF /B3 100
RF2 /VC2F /B2 100
.end
