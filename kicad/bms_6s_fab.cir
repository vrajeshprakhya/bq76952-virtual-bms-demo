.title KiCad schematic
R11 +3V3 /VREFP 0
C10 +3V3 GND 4.7u
R3 /+3V3REG +3V3 0
C8 +3V3 GND 100n
C9 +3V3 GND 100n
C12 /NRST GND 100n
C6 /TS1 GND 100n
TH1 __TH1
C5 /CAP2 GND 1u
C4 /CAP1 GND 1u
R2 /B6 /REGSRC 100
R1 /B6 /BATRC 100
C3 /+3V3REG GND 1u
R12 +3V3 /SDA 4.7k
R13 +3V3 /SCL 4.7k
C2 /REGSRC GND 1u
C1 /BATRC GND 1u
J3 __J3
R14 +3V3 /+3V3_SWD 0
C11 /VREFP GND 100n
U2 __U2
D1 __D1
R15 /LED /LEDK 1k
R5 /SRP_K /SRP 100
Q1 __Q1
RS1 __RS1
R8 /DSG_G /SRB 10k
R7 /DSG_DRV /DSG_G 100
J2 __J2
CF5 /VC7F /VC6F 1u
CF4 /VC6F /VC5BF 1u
U1 __U1
CF3 /VC3F /VC2F 1u
RF2 /B2 /VC2F 100
CF6 /VC8F /VC7F 1u
RF5 /B4 /VC6F 100
RF3 /B3 /VC3F 100
RF4 /B3 /VC5BF 100
CF1 /VC1F /VC0F 1u
CF2 /VC2F /VC1F 1u
RF0 GND /VC0F 100
RF1 /B1 /VC1F 100
RF6 /B5 /VC7F 100
RF7 /B6 /VC8F 100
J1 __J1
C7 /SRP /SRN 100n
R6 /SRN_K /SRN 100
R9 /CHG_DRV /CHG_G 100
Q2 __Q2
R10 /CHG_G /PACK_M 10k
.end
